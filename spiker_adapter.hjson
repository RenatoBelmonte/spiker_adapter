{
    name: "spiker_adapter",
    clock_primary: "clk_i",
    reset_primary: "rst_ni",
    bus_interfaces: [{ protocol: "reg_iface", direction: "device"}],

    regwidth: "32",
    registers: [
        { multireg:
          { name: "SPIKES",
            desc: "Subword of Spikes",
            count: "25",
            cname: "SPIKES",
            swaccess: "rw",
            fields: [
                { bits: "31:0"
                }
            ],
          }
        },
        { multireg:
          { name: "SPIKES_RESULT",
            desc: "Subword of results.",
            count: "4",
            cname: "SPIKES_RESULT",
            swaccess: "ro",
            hwaccess: "hwo",
            hwext: "true",
            fields: [
                { bits: "31:0"
                }
            ],
          }
        },
        { name: "CTRL1",
          desc: "Controls handshaking signal of the accelerator.",
          swaccess: "wo",
          hwaccess: "hro",
          hwext: "true",
          hwqe: "true",
          fields: [
              { bits: "0", name: "SAMPLE_READY",
                desc: "Signals the presence of a new sample."
              }
              { bits: "1", name: "START",
                desc: "Signals that SPIKER can start."
              }
          ]
        },
        { name: "STATUS",
          desc: "Contains the current status of the accelerator.",
          swaccess: "ro",
          hwaccess: "hwo",
          hwext: "true",
          fields: [
              { bits: "0", name: "SAMPLE",
                desc: "Signals that SPIKER is ready for the next sample."
              }
              { bits: "1", name: "READY",
                desc: "Signals that SPIKER is has a new result."
              }
          ]
        }
    ],
}
